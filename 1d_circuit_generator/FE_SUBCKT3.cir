.SUBCKT fe_subckt3 n1 n2 Pz L GFF

.param nx=1 ny=1 nz=10

.param p_sum10(p_1,p_2,p_3,p_4,p_5,p_6,p_7,p_8,p_9,p_10)=
+  '(p_1+p_2+p_3+p_4+p_5+p_6+p_7+p_8+p_9+p_10)'

Xfe_1_1_1  L GFF n1 vfe_1_1_2
+  pz_1_1_1 0 pz_1_1_2
+  tdgl_subckt
Xfe_1_1_2  L GFF vfe_1_1_1 vfe_1_1_3
+  pz_1_1_2 pz_1_1_1 pz_1_1_3
+  tdgl_subckt
Xfe_1_1_3  L GFF vfe_1_1_2 vfe_1_1_4
+  pz_1_1_3 pz_1_1_2 pz_1_1_4
+  tdgl_subckt
Xfe_1_1_4  L GFF vfe_1_1_3 vfe_1_1_5
+  pz_1_1_4 pz_1_1_3 pz_1_1_5
+  tdgl_subckt
Xfe_1_1_5  L GFF vfe_1_1_4 vfe_1_1_6
+  pz_1_1_5 pz_1_1_4 pz_1_1_6
+  tdgl_subckt
Xfe_1_1_6  L GFF vfe_1_1_5 vfe_1_1_7
+  pz_1_1_6 pz_1_1_5 pz_1_1_7
+  tdgl_subckt
Xfe_1_1_7  L GFF vfe_1_1_6 vfe_1_1_8
+  pz_1_1_7 pz_1_1_6 pz_1_1_8
+  tdgl_subckt
Xfe_1_1_8  L GFF vfe_1_1_7 vfe_1_1_9
+  pz_1_1_8 pz_1_1_7 pz_1_1_9
+  tdgl_subckt
Xfe_1_1_9  L GFF vfe_1_1_8 vfe_1_1_10
+  pz_1_1_9 pz_1_1_8 pz_1_1_10
+  tdgl_subckt
Xfe_1_1_10  L GFF vfe_1_1_9 n2
+  pz_1_1_10 pz_1_1_9 0
+  tdgl_subckt

Xphi n1 n2
+  vfe_1_1_1 vfe_1_1_2 vfe_1_1_3 vfe_1_1_4 vfe_1_1_5 vfe_1_1_6 vfe_1_1_7 vfe_1_1_8 vfe_1_1_9 vfe_1_1_10
+  pz_1_1_1 pz_1_1_2 pz_1_1_3 pz_1_1_4 pz_1_1_5
+  pz_1_1_6 pz_1_1_7 pz_1_1_8 pz_1_1_9 pz_1_1_10
+  poisson_subckt

E_pz1 epz1 0 VOL='p_sum10(V(pz_1_1_1),V(pz_1_1_2),V(pz_1_1_3),V(pz_1_1_4),V(pz_1_1_5),V(pz_1_1_6),V(pz_1_1_7),V(pz_1_1_8),V(pz_1_1_9),V(pz_1_1_10))'

E_pz Pz 0 VOL='(V(epz1))/(nx*ny*nz)'

X_Ife n1 n2 Pz v_fe tFE='tFE' A='A' kappa='kappa'

.IC V(vfe_1_1_1)=0 V(vfe_1_1_2)=0 V(vfe_1_1_3)=0 V(vfe_1_1_4)=0 V(vfe_1_1_5)=0
.IC V(vfe_1_1_6)=0 V(vfe_1_1_7)=0 V(vfe_1_1_8)=0 V(vfe_1_1_9)=0 V(vfe_1_1_10)=0

.IC V(pz_1_1_1)=-0.11126695376255592296
.IC V(pz_1_1_2)=-0.11126695376255592296
.IC V(pz_1_1_3)=-0.11126695376255592296
.IC V(pz_1_1_4)=-0.11126695376255592296
.IC V(pz_1_1_5)=-0.11126695376255592296
.IC V(pz_1_1_6)=-0.11126695376255592296
.IC V(pz_1_1_7)=-0.11126695376255592296
.IC V(pz_1_1_8)=-0.11126695376255592296
.IC V(pz_1_1_9)=-0.11126695376255592296
.IC V(pz_1_1_10)=-0.11126695376255592296

.ENDS
