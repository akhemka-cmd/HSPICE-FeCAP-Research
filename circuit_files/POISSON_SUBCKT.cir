**** nx=1 ny=1 nz=10
.SUBCKT poisson_subckt   n1 n2
+  phi_1_1_1 phi_1_1_2 phi_1_1_3 phi_1_1_4 phi_1_1_5 phi_1_1_6 phi_1_1_7 phi_1_1_8 phi_1_1_9 phi_1_1_10
+  pz_1_1_1 pz_1_1_2 pz_1_1_3 pz_1_1_4 pz_1_1_5
+  pz_1_1_6 pz_1_1_7 pz_1_1_8 pz_1_1_9 pz_1_1_10

.param R_phi='1/( 2/(dz*dz) )'

Rphi_1_1_1  phi_1_1_1  0  1
Gphi_1_1_1  0  phi_1_1_1  CUR='R_phi*( -1/(ep0*kappa)*( (V(pz_1_1_2)-0)/(2*dz) )
+   + (V(n1)+V(phi_1_1_2))/(dz*dz) )'
Rphi_1_1_2  phi_1_1_2  0  1
Gphi_1_1_2  0  phi_1_1_2  CUR='R_phi*( -1/(ep0*kappa)*( (V(pz_1_1_3)-V(pz_1_1_1))/(2*dz) )
+   + (V(phi_1_1_1)+V(phi_1_1_3))/(dz*dz) )'
Rphi_1_1_3  phi_1_1_3  0  1
Gphi_1_1_3  0  phi_1_1_3  CUR='R_phi*( -1/(ep0*kappa)*( (V(pz_1_1_4)-V(pz_1_1_2))/(2*dz) )
+   + (V(phi_1_1_2)+V(phi_1_1_4))/(dz*dz) )'
Rphi_1_1_4  phi_1_1_4  0  1
Gphi_1_1_4  0  phi_1_1_4  CUR='R_phi*( -1/(ep0*kappa)*( (V(pz_1_1_5)-V(pz_1_1_3))/(2*dz) )
+   + (V(phi_1_1_3)+V(phi_1_1_5))/(dz*dz) )'
Rphi_1_1_5  phi_1_1_5  0  1
Gphi_1_1_5  0  phi_1_1_5  CUR='R_phi*( -1/(ep0*kappa)*( (V(pz_1_1_6)-V(pz_1_1_4))/(2*dz) )
+   + (V(phi_1_1_4)+V(phi_1_1_6))/(dz*dz) )'
Rphi_1_1_6  phi_1_1_6  0  1
Gphi_1_1_6  0  phi_1_1_6  CUR='R_phi*( -1/(ep0*kappa)*( (V(pz_1_1_7)-V(pz_1_1_5))/(2*dz) )
+   + (V(phi_1_1_5)+V(phi_1_1_7))/(dz*dz) )'
Rphi_1_1_7  phi_1_1_7  0  1
Gphi_1_1_7  0  phi_1_1_7  CUR='R_phi*( -1/(ep0*kappa)*( (V(pz_1_1_8)-V(pz_1_1_6))/(2*dz) )
+   + (V(phi_1_1_6)+V(phi_1_1_8))/(dz*dz) )'
Rphi_1_1_8  phi_1_1_8  0  1
Gphi_1_1_8  0  phi_1_1_8  CUR='R_phi*( -1/(ep0*kappa)*( (V(pz_1_1_9)-V(pz_1_1_7))/(2*dz) )
+   + (V(phi_1_1_7)+V(phi_1_1_9))/(dz*dz) )'
Rphi_1_1_9  phi_1_1_9  0  1
Gphi_1_1_9  0  phi_1_1_9  CUR='R_phi*( -1/(ep0*kappa)*( (V(pz_1_1_10)-V(pz_1_1_8))/(2*dz) )
+   + (V(phi_1_1_8)+V(phi_1_1_10))/(dz*dz) )'
Rphi_1_1_10  phi_1_1_10  0  1
Gphi_1_1_10  0  phi_1_1_10  CUR='R_phi*( -1/(ep0*kappa)*( (0-V(pz_1_1_9))/(2*dz) )
+   + (V(phi_1_1_9)+V(n2))/(dz*dz) )'

.ENDS
